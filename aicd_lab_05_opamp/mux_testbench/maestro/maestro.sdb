ADE simulation setup
Run mode: Single Run, Sweeps and Corners
Tests:
  aicd_lab_05_opamp_mux_testbench_1: aicd_lab_05_opamp/mux_testbench/config, simulator spectre
    Variables: vb2 = 1.8; vb1 = 1.8; vb0 = 1.8
