ADE simulation setup
Run mode: Single Run, Sweeps and Corners
Tests:
  aicd_lab_05_opamp_lowPassFilter_testbench_1: aicd_lab_05_opamp/lowPassFilter_testbench/config, simulator spectre
    Variables: control = 1.8; v_offset = -1.56m
    Outputs: input_offset; BW; BW_Tolerance
Specs:
  aicd_lab_05_opamp_lowPassFilter_testbench_1 / BW_Tolerance: < 50
  aicd_lab_05_opamp_lowPassFilter_testbench_1 / BW: target 100k, tolerance 100k%
