ADE simulation setup
Test aicd_lab_05_opamp_nand_testbench_1: aicd_lab_05_opamp/nand_testbench/config, simulator spectre
  Models: /cadstud/cds03/Cadence_Libraries/UMC_TECH/UMC_65/umc_65_ll_ver_B11PB/umc65ll/../Models/Spectre/l65ll_v181.lib.scs[tt_ll_rvt12, tt_ll_hvt12, tt_ll_lvt12, tt_ll_io18, tt_ll_io25od33, tt_ll_io33, tt_ll_nvt12, tt_ll_nvt12_bpw, tt_ll_nvt18, tt_ll_nvt18_bpw, tt_ll_nvt25od33, tt_ll_nvt25od33_bpw, tt_ll_nvt33, tt_ll_nvt33_bpw, tt_ll_bjt, tt_ll_diode, tt_ll_momcaps, tt_ll_ncap12, tt_ll_ncap18, tt_ll_ncap25, tt_ll_ncap33, tt_ll_pcap12, tt_ll_pcap18, tt_ll_pcap25, tt_ll_pcap33, tt_ll_res], /cadstud/cds03/Cadence_Libraries/UMC_TECH/UMC_65/umc_65_ll_ver_B11PB/umc65ll/../Models/Spectre/L65LL_RVT12_V101_RF.lib.scs[tt], /cadstud/cds03/Cadence_Libraries/UMC_TECH/UMC_65/umc_65_ll_ver_B11PB/umc65ll/../Models/Spectre/L65LL_HVT12_V101_RF.lib.scs[tt], /cadstud/cds03/Cadence_Libraries/UMC_TECH/UMC_65/umc_65_ll_ver_B11PB/umc65ll/../Models/Spectre/L65LL_LVT12_V101_RF.lib.scs[tt], /cadstud/cds03/Cadence_Libraries/UMC_TECH/UMC_65/umc_65_ll_ver_B11PB/umc65ll/../Models/Spectre/L65LL_IO18_V101_RF.lib.scs[tt], /cadstud/cds03/Cadence_Libraries/UMC_TECH/UMC_65/umc_65_ll_ver_B11PB/umc65ll/../Models/Spectre/L65LL_IO25_V101_RF.lib.scs[tt], /cadstud/cds03/Cadence_Libraries/UMC_TECH/UMC_65/umc_65_ll_ver_B11PB/umc65ll/../Models/Spectre/L65LL_IO33_V111_RF.lib.scs[tt], /cadstud/cds03/Cadence_Libraries/UMC_TECH/UMC_65/umc_65_ll_ver_B11PB/umc65ll/../Models/Spectre/L65LL_VARMIS12_V111_RF.lib.scs[typ], /cadstud/cds03/Cadence_Libraries/UMC_TECH/UMC_65/umc_65_ll_ver_B11PB/umc65ll/../Models/Spectre/L65LL_VARMIS18_V111_RF.lib.scs[typ], /cadstud/cds03/Cadence_Libraries/UMC_TECH/UMC_65/umc_65_ll_ver_B11PB/umc65ll/../Models/Spectre/L65LL_VARMIS25_V121_RF.lib.scs[typ], /cadstud/cds03/Cadence_Libraries/UMC_TECH/UMC_65/umc_65_ll_ver_B11PB/umc65ll/../Models/Spectre/L65LL_VARMIS33_V111_RF.lib.scs[typ], /cadstud/cds03/Cadence_Libraries/UMC_TECH/UMC_65/umc_65_ll_ver_B11PB/umc65ll/../Models/Spectre/L65LL_VARDIOP_V101_RF.lib.scs[typ], /cadstud/cds03/Cadence_Libraries/UMC_TECH/UMC_65/umc_65_ll_ver_B11PB/umc65ll/../Models/Spectre/momcaps_array_vp3_rfvcl_V101.lib.scs[typ], /cadstud/cds03/Cadence_Libraries/UMC_TECH/UMC_65/umc_65_ll_ver_B11PB/umc65ll/../Models/Spectre/momcaps_array_vp4_rfvcl_V101.lib.scs[typ], /cadstud/cds03/Cadence_Libraries/UMC_TECH/UMC_65/umc_65_ll_ver_B11PB/umc65ll/../Models/Spectre/momcaps_array_vp5_rfvcl_V101.lib.scs[typ], /cadstud/cds03/Cadence_Libraries/UMC_TECH/UMC_65/umc_65_ll_ver_B11PB/umc65ll/../Models/Spectre/L65_MIMCAPS_20F_KF_V101_RF.lib.scs[tt], /cadstud/cds03/Cadence_Libraries/UMC_TECH/UMC_65/umc_65_ll_ver_B11PB/umc65ll/../Models/Spectre/L65LL_RNPPO_V101_RF.lib.scs[typ], /cadstud/cds03/Cadence_Libraries/UMC_TECH/UMC_65/umc_65_ll_ver_B11PB/umc65ll/../Models/Spectre/L65LL_RNNPO_V101_RF.lib.scs[typ], /cadstud/cds03/Cadence_Libraries/UMC_TECH/UMC_65/umc_65_ll_ver_B11PB/umc65ll/../Models/Spectre/L65LL_RNHR_V101_RF.lib.scs[typ], /cadstud/cds03/Cadence_Libraries/UMC_TECH/UMC_65/umc_65_ll_ver_B11PB/umc65ll/../Models/Spectre/L65_pad_rf_V101.lib.scs[typ], /cadstud/cds03/Cadence_Libraries/UMC_TECH/UMC_65/umc_65_ll_ver_B11PB/umc65ll/../Models/Spectre/VIL/1P8M1T1U/l_sy30k_vil_V111_RF.lib.scs[typ], /cadstud/cds03/Cadence_Libraries/UMC_TECH/UMC_65/umc_65_ll_ver_B11PB/umc65ll/../Models/Spectre/VIL/1P8M1T1U/l_syct30k_vil_V111_RF.lib.scs[typ], /cadstud/cds03/Cadence_Libraries/UMC_TECH/UMC_65/umc_65_ll_ver_B11PB/umc65ll/../Models/Spectre/VIL/1P8M1T1U/l_slcr30k_vil_V111_RF.lib.scs[typ], /cadstud/cds03/Cadence_Libraries/UMC_TECH/UMC_65/umc_65_ll_ver_B11PB/umc65ll/../Models/Spectre/VIL/1P8M1T1U/l_sqsk_vil_V111_RF.lib.scs[typ], /cadstud/cds03/Cadence_Libraries/UMC_TECH/UMC_65/umc_65_ll_ver_B11PB/umc65ll/../Models/Spectre/VTL/1P8M1T1U/l_occtout_trans_rfvil_V101.lib.scs[typ], /cadstud/cds03/Cadence_Libraries/UMC_TECH/UMC_65/umc_65_ll_ver_B11PB/umc65ll/../Models/Spectre/VTL/1P8M1T1U/l_sq_trans_rfvil_V101.lib.scs[typ], /cadstud/cds03/Cadence_Libraries/UMC_TECH/UMC_65/umc_65_ll_ver_B11PB/umc65ll/../Models/Spectre/VTL/1P8M1T1U/l_sqctin_trans_rfvil_V101.lib.scs[typ], /cadstud/cds03/Cadence_Libraries/UMC_TECH/UMC_65/umc_65_ll_ver_B11PB/umc65ll/../Models/Spectre/VTL/1P8M1T1U/l_sqctinout_trans_rfvil_V101.lib.scs[typ], /cadstud/cds03/Cadence_Libraries/UMC_TECH/UMC_65/umc_65_ll_ver_B11PB/umc65ll/../Models/Spectre/VTL/1P8M1T1U/l_sqctout_trans_rfvil_V101.lib.scs[typ]
  Temperature: 27
  Analysis dc: (saves the operating point)
  Output 000 = VDC("/000Vout")
  Output 001 = VDC("/001Vout")
  Output 010 = VDC("/010Vout")
  Output 100 = VDC("/100Vout")
  Output 101 = VDC("/101Vout")
  Output 110 = VDC("/110Vout")
  Output 111 = VDC("/111Vout")
  Signals: /111Vout, /000Vout, /110Vout, /100Vout, /001Vout, /010Vout, /101Vout
Run mode: Single Run, Sweeps and Corners
