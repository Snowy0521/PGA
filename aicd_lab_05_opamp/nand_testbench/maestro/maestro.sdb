ADE simulation setup
Run mode: Single Run, Sweeps and Corners
Tests:
  aicd_lab_05_opamp_nand_testbench_1: aicd_lab_05_opamp/nand_testbench/config, simulator spectre
