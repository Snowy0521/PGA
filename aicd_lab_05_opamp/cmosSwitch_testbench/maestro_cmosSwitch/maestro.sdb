ADE simulation setup
Run mode: Single Run, Sweeps and Corners
Tests:
  aicd_lab_05_opamp_cmosSwitch_testbench_1: aicd_lab_05_opamp/cmosSwitch_testbench/config, simulator spectre
    Variables: DCin = 0.9
    Outputs: Ron; Ron_max; Roff; Roff_min
