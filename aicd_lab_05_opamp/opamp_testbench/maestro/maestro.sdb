ADE simulation setup
Run mode: Single Run, Sweeps and Corners
Tests:
  aicd_lab_05_opamp_opamp_testbench_1: aicd_lab_05_opamp/opamp_testbench/config, simulator spectre
    Variables: vcm = 0.9; v_offset = 922.8u; vdd = 1.8; v_sweep = 0.9/0.05*v_offset+0.9
    Outputs: ST_high; ST_low; SR-|v/us; Loop Gain dB20; Gain Margin; SR+|v/us
Global variables:
  sigma = 3
Corners:
  model folders: /cadstud/cds03/Cadence_Libraries/UMC_TECH/UMC_65/umc_65_ll_ver_B11PB/Models/Spectre, /cadstud/cds03/Cadence_Libraries/UMC_TECH/UMC_65/umc_65_ll_ver_B11PB/Models/Spectre/Monte_Carlo
  Corner (off): temperature=-25 85; vdd=1.62 1.98; L65_MIMCAPS_20F_KF_V101_RF.lib.scs[ff ss], l65ll_v181.lib.scs[ff_ll_io25od33 fnsp_ll_io25od33 snfp_ll_io25od33 ss_ll_io25od33, ff_ll_res ss_ll_res]
  MonteCarlo (off): vdd=1.8; l65ll_v181_mc.lib.scs[mc_ll_io25od33, mc_ll_res], L65_MIMCAPS_20F_KF_V101_RF_MC.lib.scs[mc]
  Corner_0 (off): temperature=-25 85; vdd=1.62 1.98; L65_MIMCAPS_20F_KF_V101_RF.lib.scs[ff ss], l65ll_v181.lib.scs[ff_ll_io25od33 fnsp_ll_io25od33 snfp_ll_io25od33 ss_ll_io25od33, ff_ll_res ss_ll_res]
  MonteCarlo_0 (off): vdd=1.8; l65ll_v181_mc.lib.scs[mc_ll_io25od33, mc_ll_res], L65_MIMCAPS_20F_KF_V101_RF_MC.lib.scs[mc]
  Corner_1 (off): temperature=-25 85; vdd=1.62 1.98; L65_MIMCAPS_20F_KF_V101_RF.lib.scs[ff ss], l65ll_v181.lib.scs[ff_ll_io25od33 fnsp_ll_io25od33 snfp_ll_io25od33 ss_ll_io25od33, ff_ll_res ss_ll_res]
  MonteCarlo_1 (off): vdd=1.8; l65ll_v181_mc.lib.scs[mc_ll_io25od33, mc_ll_res], L65_MIMCAPS_20F_KF_V101_RF_MC.lib.scs[mc]
  Corner_0_0 (off): temperature=-25 85; vdd=1.62 1.98; L65_MIMCAPS_20F_KF_V101_RF.lib.scs[ff ss], l65ll_v181.lib.scs[ff_ll_io25od33 fnsp_ll_io25od33 snfp_ll_io25od33 ss_ll_io25od33, ff_ll_res ss_ll_res]
  MonteCarlo_0_0 (off): vdd=1.8; l65ll_v181_mc.lib.scs[mc_ll_io25od33, mc_ll_res], L65_MIMCAPS_20F_KF_V101_RF_MC.lib.scs[mc]
  Corner_2 (off): temperature=-25 85; vdd=1.62 1.98; L65_MIMCAPS_20F_KF_V101_RF.lib.scs[ff ss], l65ll_v181.lib.scs[ff_ll_io25od33 fnsp_ll_io25od33 snfp_ll_io25od33 ss_ll_io25od33, ff_ll_res ss_ll_res]
  MonteCarlo_2 (off): vdd=1.8; l65ll_v181_mc.lib.scs[mc_ll_io25od33, mc_ll_res], L65_MIMCAPS_20F_KF_V101_RF_MC.lib.scs[mc]
  Corner_3 (off): temperature=-25 85; vdd=1.62 1.98; L65_MIMCAPS_20F_KF_V101_RF.lib.scs[ff ss], l65ll_v181.lib.scs[ff_ll_io25od33 fnsp_ll_io25od33 snfp_ll_io25od33 ss_ll_io25od33, ff_ll_res ss_ll_res]
  MonteCarlo_3 (off): vdd=1.8; l65ll_v181_mc.lib.scs[mc_ll_io25od33, mc_ll_res], L65_MIMCAPS_20F_KF_V101_RF_MC.lib.scs[mc]
Specs:
  aicd_lab_05_opamp_opamp_testbench_1 / DC Gain|dB: > 50
  aicd_lab_05_opamp_opamp_testbench_1 / GBW|Hz: > 20M
  aicd_lab_05_opamp_opamp_testbench_1 / input_offset|volt: range -5m to 5m
  aicd_lab_05_opamp_opamp_testbench_1 / PM|grad: > 55
  aicd_lab_05_opamp_opamp_testbench_1 / CMRR|dB: > 60
  aicd_lab_05_opamp_opamp_testbench_1 / SR+|v/us: > 15
  aicd_lab_05_opamp_opamp_testbench_1 / Input Noise at 20kHz: < 55n
  aicd_lab_05_opamp_opamp_testbench_1 / DC Power: < 0.6m
  aicd_lab_05_opamp_opamp_testbench_1 / Out_swing_volt_max: > 1.5
  aicd_lab_05_opamp_opamp_testbench_1 / Out_swing_volt_min: < 0.3
  aicd_lab_05_opamp_opamp_testbench_1 / ICMR_max: > 1.3
  aicd_lab_05_opamp_opamp_testbench_1 / ICMR_min: < 0.5
  aicd_lab_05_opamp_opamp_testbench_1 / SR-|v/us: > 15
  aicd_lab_05_opamp_opamp_testbench_1 / ST_low: < 500n
  aicd_lab_05_opamp_opamp_testbench_1 / ST_high: < 500n
