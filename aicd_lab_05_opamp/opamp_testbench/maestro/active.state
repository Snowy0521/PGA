ADE simulation setup
Test aicd_lab_05_opamp_opamp_testbench_1: aicd_lab_05_opamp/opamp_testbench/config, simulator spectre
  Models: /cadstud/cds03/Cadence_Libraries/UMC_TECH/UMC_65/umc_65_ll_ver_B11PB/umc65ll/../Models/Spectre/l65ll_v181.lib.scs[tt_ll_rvt12, tt_ll_hvt12, tt_ll_lvt12, tt_ll_io18, tt_ll_io25od33, tt_ll_io33, tt_ll_nvt12, tt_ll_nvt12_bpw, tt_ll_nvt18, tt_ll_nvt18_bpw, tt_ll_nvt25od33, tt_ll_nvt25od33_bpw, tt_ll_nvt33, tt_ll_nvt33_bpw, tt_ll_bjt, tt_ll_diode, tt_ll_momcaps, tt_ll_ncap12, tt_ll_ncap18, tt_ll_ncap25, tt_ll_ncap33, tt_ll_pcap12, tt_ll_pcap18, tt_ll_pcap25, tt_ll_pcap33, tt_ll_res], /cadstud/cds03/Cadence_Libraries/UMC_TECH/UMC_65/umc_65_ll_ver_B11PB/umc65ll/../Models/Spectre/L65LL_RVT12_V101_RF.lib.scs[tt], /cadstud/cds03/Cadence_Libraries/UMC_TECH/UMC_65/umc_65_ll_ver_B11PB/umc65ll/../Models/Spectre/L65LL_HVT12_V101_RF.lib.scs[tt], /cadstud/cds03/Cadence_Libraries/UMC_TECH/UMC_65/umc_65_ll_ver_B11PB/umc65ll/../Models/Spectre/L65LL_LVT12_V101_RF.lib.scs[tt], /cadstud/cds03/Cadence_Libraries/UMC_TECH/UMC_65/umc_65_ll_ver_B11PB/umc65ll/../Models/Spectre/L65LL_IO18_V101_RF.lib.scs[tt], /cadstud/cds03/Cadence_Libraries/UMC_TECH/UMC_65/umc_65_ll_ver_B11PB/umc65ll/../Models/Spectre/L65LL_IO25_V101_RF.lib.scs[tt], /cadstud/cds03/Cadence_Libraries/UMC_TECH/UMC_65/umc_65_ll_ver_B11PB/umc65ll/../Models/Spectre/L65LL_IO33_V111_RF.lib.scs[tt], /cadstud/cds03/Cadence_Libraries/UMC_TECH/UMC_65/umc_65_ll_ver_B11PB/umc65ll/../Models/Spectre/L65LL_VARMIS12_V111_RF.lib.scs[typ], /cadstud/cds03/Cadence_Libraries/UMC_TECH/UMC_65/umc_65_ll_ver_B11PB/umc65ll/../Models/Spectre/L65LL_VARMIS18_V111_RF.lib.scs[typ], /cadstud/cds03/Cadence_Libraries/UMC_TECH/UMC_65/umc_65_ll_ver_B11PB/umc65ll/../Models/Spectre/L65LL_VARMIS25_V121_RF.lib.scs[typ], /cadstud/cds03/Cadence_Libraries/UMC_TECH/UMC_65/umc_65_ll_ver_B11PB/umc65ll/../Models/Spectre/L65LL_VARMIS33_V111_RF.lib.scs[typ], /cadstud/cds03/Cadence_Libraries/UMC_TECH/UMC_65/umc_65_ll_ver_B11PB/umc65ll/../Models/Spectre/L65LL_VARDIOP_V101_RF.lib.scs[typ], /cadstud/cds03/Cadence_Libraries/UMC_TECH/UMC_65/umc_65_ll_ver_B11PB/umc65ll/../Models/Spectre/momcaps_array_vp3_rfvcl_V101.lib.scs[typ], /cadstud/cds03/Cadence_Libraries/UMC_TECH/UMC_65/umc_65_ll_ver_B11PB/umc65ll/../Models/Spectre/momcaps_array_vp4_rfvcl_V101.lib.scs[typ], /cadstud/cds03/Cadence_Libraries/UMC_TECH/UMC_65/umc_65_ll_ver_B11PB/umc65ll/../Models/Spectre/momcaps_array_vp5_rfvcl_V101.lib.scs[typ], /cadstud/cds03/Cadence_Libraries/UMC_TECH/UMC_65/umc_65_ll_ver_B11PB/umc65ll/../Models/Spectre/L65_MIMCAPS_20F_KF_V101_RF.lib.scs[tt], /cadstud/cds03/Cadence_Libraries/UMC_TECH/UMC_65/umc_65_ll_ver_B11PB/umc65ll/../Models/Spectre/L65LL_RNPPO_V101_RF.lib.scs[typ], /cadstud/cds03/Cadence_Libraries/UMC_TECH/UMC_65/umc_65_ll_ver_B11PB/umc65ll/../Models/Spectre/L65LL_RNNPO_V101_RF.lib.scs[typ], /cadstud/cds03/Cadence_Libraries/UMC_TECH/UMC_65/umc_65_ll_ver_B11PB/umc65ll/../Models/Spectre/L65LL_RNHR_V101_RF.lib.scs[typ], /cadstud/cds03/Cadence_Libraries/UMC_TECH/UMC_65/umc_65_ll_ver_B11PB/umc65ll/../Models/Spectre/L65_pad_rf_V101.lib.scs[typ], /cadstud/cds03/Cadence_Libraries/UMC_TECH/UMC_65/umc_65_ll_ver_B11PB/umc65ll/../Models/Spectre/VIL/1P8M1T1U/l_sy30k_vil_V111_RF.lib.scs[typ], /cadstud/cds03/Cadence_Libraries/UMC_TECH/UMC_65/umc_65_ll_ver_B11PB/umc65ll/../Models/Spectre/VIL/1P8M1T1U/l_syct30k_vil_V111_RF.lib.scs[typ], /cadstud/cds03/Cadence_Libraries/UMC_TECH/UMC_65/umc_65_ll_ver_B11PB/umc65ll/../Models/Spectre/VIL/1P8M1T1U/l_slcr30k_vil_V111_RF.lib.scs[typ], /cadstud/cds03/Cadence_Libraries/UMC_TECH/UMC_65/umc_65_ll_ver_B11PB/umc65ll/../Models/Spectre/VIL/1P8M1T1U/l_sqsk_vil_V111_RF.lib.scs[typ], /cadstud/cds03/Cadence_Libraries/UMC_TECH/UMC_65/umc_65_ll_ver_B11PB/umc65ll/../Models/Spectre/VTL/1P8M1T1U/l_occtout_trans_rfvil_V101.lib.scs[typ], /cadstud/cds03/Cadence_Libraries/UMC_TECH/UMC_65/umc_65_ll_ver_B11PB/umc65ll/../Models/Spectre/VTL/1P8M1T1U/l_sq_trans_rfvil_V101.lib.scs[typ], /cadstud/cds03/Cadence_Libraries/UMC_TECH/UMC_65/umc_65_ll_ver_B11PB/umc65ll/../Models/Spectre/VTL/1P8M1T1U/l_sqctin_trans_rfvil_V101.lib.scs[typ], /cadstud/cds03/Cadence_Libraries/UMC_TECH/UMC_65/umc_65_ll_ver_B11PB/umc65ll/../Models/Spectre/VTL/1P8M1T1U/l_sqctinout_trans_rfvil_V101.lib.scs[typ], /cadstud/cds03/Cadence_Libraries/UMC_TECH/UMC_65/umc_65_ll_ver_B11PB/umc65ll/../Models/Spectre/VTL/1P8M1T1U/l_sqctout_trans_rfvil_V101.lib.scs[typ]
  Variables: vcm = 0.9; v_offset = 922.8u; vdd = 1.8; v_sweep = 0.9/0.05*v_offset+0.9
  Temperature: 27
  Analysis stb: start=1 stop=1G dec=80 probe=/V19 stbProbeMode=single-ended
  Analysis ac: start=1 stop=1G dec=80
  Analysis dc: sweep v_offset start=-0.05 stop=0.05 (saves the operating point)
  Analysis tran: stop=10u
  Analysis noise: start=1 stop=100M dec=50 p=/out_noise iprobe=/V13
  Output Vout_offset_graph = VS("/out_offset") (unticked)
  Output input_offset|volt = cross(VS("/out_offset") 0.9 1 "rising" nil nil nil) (unticked)
  Output DC Gain_graph = dB20((VF("/out_OL") / VF("/inp"))) (unticked)
  Output Phase Margin_graph = phaseDegUnwrapped((VF("/out_OL") / VF("/inp"))) (unticked)
  Output DC Gain|dB = ymax(dB20((VF("/out_OL") / VF("/inp")))) (unticked)
  Output GBW|Hz = cross(dB20((VF("/out_OL") / VF("/inp"))) "1" 1 "falling" nil nil nil) (unticked)
  Output PM|grad = phaseMargin((VF("/out_OL") / VF("/inp"))) (unticked)
  Output CM Gain_graph = dB20((VF("/out_CMRR") / VF("/inp_CMRR"))) (unticked)
  Output CM Gain|dB = ymax(dB20((VF("/out_CMRR") / VF("/inp_CMRR")))) (unticked)
  Output CMRR|dB = (ymax(dB20((VF("/out_OL") / VF("/inp")))) - ymax(dB20((VF("/out_CMRR") / VF("/inp_CMRR"))))) (unticked)
  Output Vout_swing = VT("/out_swing")
  Output Vin_swing = VT("/in_swing")
  Output Vout_ICMR = VS("/out_ICMR") (unticked)
  Output Vin_ICMR = VS("/in_ICMR") (unticked)
  Output Vout_SR+ = VT("/out_SR+") (unticked)
  Output Vin_SR+ = VT("/in_SR+") (unticked)
  Output SR+|v/us = (slewRate(VT("/out_SR+") 0.7 nil 1.1 nil 10 90 nil "time") / 1000000) (unticked)
  Output Vout_SR- = VT("/out_SR-") (unticked)
  Output Vin_SR- = VT("/in_SR-") (unticked)
  Output SR-|v/us = (slewRate(VT("/out_SR-") 1.1 nil 0.7 nil 90 10 nil "time") / 1000000) (unticked)
  Output ST_low = (settlingTime(VT("/out_SR-") 9.4e-07 t 1.06e-06 t 5 nil "time") - 1.017633e-06) (unticked)
  Output ST_high = (settlingTime(VT("/out_SR+") 9e-07 t 1.05e-06 t 5 nil "time") - 1.000019e-06) (unticked)
  Output Input Noise at 20kHz = value(getData("/in" ?result "noise") 20000) (unticked)
  Output DC Power = (IDC("/I2/Vdd") * VDC("/net3")) (unticked)
  Output Out_swing_volt_max = ymax(VT("/out_swing")) (unticked)
  Output Input Noise_graph = getData("/in" ?result "noise") (unticked)
  Output Out_swing_volt_min = ymin(VT("/out_swing")) (unticked)
  Output ICMR_max = ymax(VS("/out_ICMR")) (unticked)
  Output ICMR_min = ymin(VS("/out_ICMR")) (unticked)
  Output Loop Gain Phase = phaseDegUnwrapped(getData("loopGain" ?result "stb")) (unticked)
  Output Loop Gain dB20 = value(db(mag(getData("loopGain" ?result "stb"))) 1) (unticked)
  Output Phase Margin = getData("phaseMargin" ?result "stb_margin") (unticked)
  Output Gain Margin = cross(db(mag(getData("loopGain" ?result "stb"))) "1" 1 "falling" nil nil nil) (unticked)
  Signals: /out_offset, /inp_offset, /out_OL, /inp, /out_CMRR, /inp_CMRR, /out_swing, /in_swing, /out_ICMR, /in_ICMR, /out_SR+, /in_SR+, /out_SR-, /in_SR-, /I2/Vdd (terminal), /net3
Run mode: Single Run, Sweeps and Corners
Global variables:
  sigma = 3
Corners:
  model folders: /cadstud/cds03/Cadence_Libraries/UMC_TECH/UMC_65/umc_65_ll_ver_B11PB/Models/Spectre, /cadstud/cds03/Cadence_Libraries/UMC_TECH/UMC_65/umc_65_ll_ver_B11PB/Models/Spectre/Monte_Carlo
  Corner (off): temperature=-25 85; vdd=1.62 1.98; L65_MIMCAPS_20F_KF_V101_RF.lib.scs[ff ss], l65ll_v181.lib.scs[ff_ll_io25od33 fnsp_ll_io25od33 snfp_ll_io25od33 ss_ll_io25od33, ff_ll_res ss_ll_res]
  MonteCarlo (off): vdd=1.8; l65ll_v181_mc.lib.scs[mc_ll_io25od33, mc_ll_res], L65_MIMCAPS_20F_KF_V101_RF_MC.lib.scs[mc]
  Corner_0 (off): temperature=-25 85; vdd=1.62 1.98; L65_MIMCAPS_20F_KF_V101_RF.lib.scs[ff ss], l65ll_v181.lib.scs[ff_ll_io25od33 fnsp_ll_io25od33 snfp_ll_io25od33 ss_ll_io25od33, ff_ll_res ss_ll_res]
  MonteCarlo_0 (off): vdd=1.8; l65ll_v181_mc.lib.scs[mc_ll_io25od33, mc_ll_res], L65_MIMCAPS_20F_KF_V101_RF_MC.lib.scs[mc]
  Corner_1 (off): temperature=-25 85; vdd=1.62 1.98; L65_MIMCAPS_20F_KF_V101_RF.lib.scs[ff ss], l65ll_v181.lib.scs[ff_ll_io25od33 fnsp_ll_io25od33 snfp_ll_io25od33 ss_ll_io25od33, ff_ll_res ss_ll_res]
  MonteCarlo_1 (off): vdd=1.8; l65ll_v181_mc.lib.scs[mc_ll_io25od33, mc_ll_res], L65_MIMCAPS_20F_KF_V101_RF_MC.lib.scs[mc]
  Corner_0_0 (off): temperature=-25 85; vdd=1.62 1.98; L65_MIMCAPS_20F_KF_V101_RF.lib.scs[ff ss], l65ll_v181.lib.scs[ff_ll_io25od33 fnsp_ll_io25od33 snfp_ll_io25od33 ss_ll_io25od33, ff_ll_res ss_ll_res]
  MonteCarlo_0_0 (off): vdd=1.8; l65ll_v181_mc.lib.scs[mc_ll_io25od33, mc_ll_res], L65_MIMCAPS_20F_KF_V101_RF_MC.lib.scs[mc]
  Corner_2 (off): temperature=-25 85; vdd=1.62 1.98; L65_MIMCAPS_20F_KF_V101_RF.lib.scs[ff ss], l65ll_v181.lib.scs[ff_ll_io25od33 fnsp_ll_io25od33 snfp_ll_io25od33 ss_ll_io25od33, ff_ll_res ss_ll_res]
  MonteCarlo_2 (off): vdd=1.8; l65ll_v181_mc.lib.scs[mc_ll_io25od33, mc_ll_res], L65_MIMCAPS_20F_KF_V101_RF_MC.lib.scs[mc]
  Corner_3 (off): temperature=-25 85; vdd=1.62 1.98; L65_MIMCAPS_20F_KF_V101_RF.lib.scs[ff ss], l65ll_v181.lib.scs[ff_ll_io25od33 fnsp_ll_io25od33 snfp_ll_io25od33 ss_ll_io25od33, ff_ll_res ss_ll_res]
  MonteCarlo_3 (off): vdd=1.8; l65ll_v181_mc.lib.scs[mc_ll_io25od33, mc_ll_res], L65_MIMCAPS_20F_KF_V101_RF_MC.lib.scs[mc]
Specs:
  aicd_lab_05_opamp_opamp_testbench_1 / DC Gain|dB: > 50
  aicd_lab_05_opamp_opamp_testbench_1 / GBW|Hz: > 20M
  aicd_lab_05_opamp_opamp_testbench_1 / input_offset|volt: range -5m to 5m
  aicd_lab_05_opamp_opamp_testbench_1 / PM|grad: > 55
  aicd_lab_05_opamp_opamp_testbench_1 / CMRR|dB: > 60
  aicd_lab_05_opamp_opamp_testbench_1 / SR+|v/us: > 15
  aicd_lab_05_opamp_opamp_testbench_1 / Input Noise at 20kHz: < 55n
  aicd_lab_05_opamp_opamp_testbench_1 / DC Power: < 0.6m
  aicd_lab_05_opamp_opamp_testbench_1 / Out_swing_volt_max: > 1.5
  aicd_lab_05_opamp_opamp_testbench_1 / Out_swing_volt_min: < 0.3
  aicd_lab_05_opamp_opamp_testbench_1 / ICMR_max: > 1.3
  aicd_lab_05_opamp_opamp_testbench_1 / ICMR_min: < 0.5
  aicd_lab_05_opamp_opamp_testbench_1 / SR-|v/us: > 15
  aicd_lab_05_opamp_opamp_testbench_1 / ST_low: < 500n
  aicd_lab_05_opamp_opamp_testbench_1 / ST_high: < 500n
