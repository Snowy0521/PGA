ADE simulation setup
Test aicd_lab_05_opamp_PGAandLPF_1: aicd_lab_05_opamp/PGAandLPF_Testbench/config, simulator spectre
  Models: /cadstud/cds03/Cadence_Libraries/UMC_TECH/UMC_65/umc_65_ll_ver_B11PB/umc65ll/../Models/Spectre/l65ll_v181.lib.scs[tt_ll_rvt12, tt_ll_hvt12, tt_ll_lvt12, tt_ll_io18, tt_ll_io25od33, tt_ll_io33, tt_ll_nvt12, tt_ll_nvt12_bpw, tt_ll_nvt18, tt_ll_nvt18_bpw, tt_ll_nvt25od33, tt_ll_nvt25od33_bpw, tt_ll_nvt33, tt_ll_nvt33_bpw, tt_ll_bjt, tt_ll_diode, tt_ll_momcaps, tt_ll_ncap12, tt_ll_ncap18, tt_ll_ncap25, tt_ll_ncap33, tt_ll_pcap12, tt_ll_pcap18, tt_ll_pcap25, tt_ll_pcap33, tt_ll_res], /cadstud/cds03/Cadence_Libraries/UMC_TECH/UMC_65/umc_65_ll_ver_B11PB/umc65ll/../Models/Spectre/L65LL_RVT12_V101_RF.lib.scs[tt], /cadstud/cds03/Cadence_Libraries/UMC_TECH/UMC_65/umc_65_ll_ver_B11PB/umc65ll/../Models/Spectre/L65LL_HVT12_V101_RF.lib.scs[tt], /cadstud/cds03/Cadence_Libraries/UMC_TECH/UMC_65/umc_65_ll_ver_B11PB/umc65ll/../Models/Spectre/L65LL_LVT12_V101_RF.lib.scs[tt], /cadstud/cds03/Cadence_Libraries/UMC_TECH/UMC_65/umc_65_ll_ver_B11PB/umc65ll/../Models/Spectre/L65LL_IO18_V101_RF.lib.scs[tt], /cadstud/cds03/Cadence_Libraries/UMC_TECH/UMC_65/umc_65_ll_ver_B11PB/umc65ll/../Models/Spectre/L65LL_IO25_V101_RF.lib.scs[tt], /cadstud/cds03/Cadence_Libraries/UMC_TECH/UMC_65/umc_65_ll_ver_B11PB/umc65ll/../Models/Spectre/L65LL_IO33_V111_RF.lib.scs[tt], /cadstud/cds03/Cadence_Libraries/UMC_TECH/UMC_65/umc_65_ll_ver_B11PB/umc65ll/../Models/Spectre/L65LL_VARMIS12_V111_RF.lib.scs[typ], /cadstud/cds03/Cadence_Libraries/UMC_TECH/UMC_65/umc_65_ll_ver_B11PB/umc65ll/../Models/Spectre/L65LL_VARMIS18_V111_RF.lib.scs[typ], /cadstud/cds03/Cadence_Libraries/UMC_TECH/UMC_65/umc_65_ll_ver_B11PB/umc65ll/../Models/Spectre/L65LL_VARMIS25_V121_RF.lib.scs[typ], /cadstud/cds03/Cadence_Libraries/UMC_TECH/UMC_65/umc_65_ll_ver_B11PB/umc65ll/../Models/Spectre/L65LL_VARMIS33_V111_RF.lib.scs[typ], /cadstud/cds03/Cadence_Libraries/UMC_TECH/UMC_65/umc_65_ll_ver_B11PB/umc65ll/../Models/Spectre/L65LL_VARDIOP_V101_RF.lib.scs[typ], /cadstud/cds03/Cadence_Libraries/UMC_TECH/UMC_65/umc_65_ll_ver_B11PB/umc65ll/../Models/Spectre/momcaps_array_vp3_rfvcl_V101.lib.scs[typ], /cadstud/cds03/Cadence_Libraries/UMC_TECH/UMC_65/umc_65_ll_ver_B11PB/umc65ll/../Models/Spectre/momcaps_array_vp4_rfvcl_V101.lib.scs[typ], /cadstud/cds03/Cadence_Libraries/UMC_TECH/UMC_65/umc_65_ll_ver_B11PB/umc65ll/../Models/Spectre/momcaps_array_vp5_rfvcl_V101.lib.scs[typ], /cadstud/cds03/Cadence_Libraries/UMC_TECH/UMC_65/umc_65_ll_ver_B11PB/umc65ll/../Models/Spectre/L65_MIMCAPS_20F_KF_V101_RF.lib.scs[tt], /cadstud/cds03/Cadence_Libraries/UMC_TECH/UMC_65/umc_65_ll_ver_B11PB/umc65ll/../Models/Spectre/L65LL_RNPPO_V101_RF.lib.scs[typ], /cadstud/cds03/Cadence_Libraries/UMC_TECH/UMC_65/umc_65_ll_ver_B11PB/umc65ll/../Models/Spectre/L65LL_RNNPO_V101_RF.lib.scs[typ], /cadstud/cds03/Cadence_Libraries/UMC_TECH/UMC_65/umc_65_ll_ver_B11PB/umc65ll/../Models/Spectre/L65LL_RNHR_V101_RF.lib.scs[typ], /cadstud/cds03/Cadence_Libraries/UMC_TECH/UMC_65/umc_65_ll_ver_B11PB/umc65ll/../Models/Spectre/L65_pad_rf_V101.lib.scs[typ], /cadstud/cds03/Cadence_Libraries/UMC_TECH/UMC_65/umc_65_ll_ver_B11PB/umc65ll/../Models/Spectre/VIL/1P8M1T1U/l_sy30k_vil_V111_RF.lib.scs[typ], /cadstud/cds03/Cadence_Libraries/UMC_TECH/UMC_65/umc_65_ll_ver_B11PB/umc65ll/../Models/Spectre/VIL/1P8M1T1U/l_syct30k_vil_V111_RF.lib.scs[typ], /cadstud/cds03/Cadence_Libraries/UMC_TECH/UMC_65/umc_65_ll_ver_B11PB/umc65ll/../Models/Spectre/VIL/1P8M1T1U/l_slcr30k_vil_V111_RF.lib.scs[typ], /cadstud/cds03/Cadence_Libraries/UMC_TECH/UMC_65/umc_65_ll_ver_B11PB/umc65ll/../Models/Spectre/VIL/1P8M1T1U/l_sqsk_vil_V111_RF.lib.scs[typ], /cadstud/cds03/Cadence_Libraries/UMC_TECH/UMC_65/umc_65_ll_ver_B11PB/umc65ll/../Models/Spectre/VTL/1P8M1T1U/l_occtout_trans_rfvil_V101.lib.scs[typ], /cadstud/cds03/Cadence_Libraries/UMC_TECH/UMC_65/umc_65_ll_ver_B11PB/umc65ll/../Models/Spectre/VTL/1P8M1T1U/l_sq_trans_rfvil_V101.lib.scs[typ], /cadstud/cds03/Cadence_Libraries/UMC_TECH/UMC_65/umc_65_ll_ver_B11PB/umc65ll/../Models/Spectre/VTL/1P8M1T1U/l_sqctin_trans_rfvil_V101.lib.scs[typ], /cadstud/cds03/Cadence_Libraries/UMC_TECH/UMC_65/umc_65_ll_ver_B11PB/umc65ll/../Models/Spectre/VTL/1P8M1T1U/l_sqctinout_trans_rfvil_V101.lib.scs[typ], /cadstud/cds03/Cadence_Libraries/UMC_TECH/UMC_65/umc_65_ll_ver_B11PB/umc65ll/../Models/Spectre/VTL/1P8M1T1U/l_sqctout_trans_rfvil_V101.lib.scs[typ]
  Variables: v_offset = -1.888u; vb0_0 = 0; vb0_1 = 1.8; vb1_0 = 0; vb1_1 = 1.8; vb2_0 = 0; vb2_1 = 1.8; vcontrol = 1.8; vdd = 1.8; vcm = 0.9
  Temperature: 27
  Analysis dc: sweep v_offset start=-0.05 stop=0.05 (saves the operating point)
  Analysis ac: start=1 stop=1G dec=80
  Output input_offset = cross(VS("/vout_s0") 0.9 1 "rising" nil nil nil)
  Output vout_offset = VS("/vout_s0")
  Output Vcm = VDC("/vcm")
  Output Vdd = VDC("/vdd")
  Output FilterBW = cross(dB20((VF("/vout_s0") / VF("/vin_filter"))) "-3" 1 "falling" nil nil nil) (unticked)
  Output BW Tolerance = (abs(((cross(dB20((VF("/vout_s0") / VF("/vin_filter"))) "-3" 1 "falling" nil nil nil) - 100000) / 100000)) * 100) (unticked)
  Output Input Impedance = (VDC("/vin_s0") / IDC("/I2/Vin")) (unticked)
  Output DC Gain S0 = ymax(dB20((VF("/vout_s0") / VF("/vin_s0"))))
  Output DC Gain S1 = ymax(dB20((VF("/vout_s1") / VF("/vin_s1"))))
  Output DC Gain S2 = ymax(dB20((VF("/vout_s2") / VF("/vin_s2"))))
  Output DC Gain S3 = ymax(dB20((VF("/vout_s3") / VF("/vin_s3"))))
  Output DC Gain S4 = ymax(dB20((VF("/vout_s4") / VF("/vin_s4"))))
  Output DC Gain S5 = ymax(dB20((VF("/vout_s5") / VF("/vin_s5"))))
  Output DC Gain S6 = ymax(dB20((VF("/vout_s6") / VF("/vin_s6"))))
  Output DC Gain S7 = ymax(dB20((VF("/vout_s7") / VF("/vin_s7"))))
  Output DNL0 = ((ymax(dB20((VF("/vout_s0") / VF("/vin_s0")))) - 0) / 3)
  Output DNL1 = ((ymax(dB20((VF("/vout_s1") / VF("/vin_s1")))) - 3) / 3)
  Output DNL2 = ((ymax(dB20((VF("/vout_s2") / VF("/vin_s2")))) - 6) / 3)
  Output DNL3 = ((ymax(dB20((VF("/vout_s3") / VF("/vin_s3")))) - 9) / 3)
  Output DNL4 = ((ymax(dB20((VF("/vout_s4") / VF("/vin_s4")))) - 12) / 3)
  Output DNL5 = ((ymax(dB20((VF("/vout_s5") / VF("/vin_s5")))) - 15) / 3)
  Output DNL6 = ((ymax(dB20((VF("/vout_s6") / VF("/vin_s6")))) - 18) / 3)
  Output DNL7 = ((ymax(dB20((VF("/vout_s7") / VF("/vin_s7")))) - 21) / 3)
  Output INL = (((ymax(dB20((VF("/vout_s0") / VF("/vin_s0")))) - 0) / 3) + ((ymax(dB20((VF("/vout_s1") / VF("/vin_s1")))) - 3) / 3) + ((ymax(dB20((VF("/vout_s2") / VF("/vin_s2")))) - 6) / 3) + ((ymax(dB20((VF("/vout_s3") / VF("/vin_s3")))) - 9) / 3) + ((ymax(dB20((VF("/vout_s4") / VF("/vin_s4")))) - 12) / 3) + ((ymax(dB20((VF("/vout_s5") / VF("/vin_s5")))) - 15) / 3) + ((ymax(dB20((VF("/vout_s6") / VF("/vin_s6")))) - 18) / 3) + ((ymax(dB20((VF("/vout_s7") / VF("/vin_s7")))) - 21) / 3))
  Signals: /vcm, /vdd, /vout_s0, /vin_s0, /vout_s1, /vin_s1, /vout_s2, /vin_s2, /vout_s3, /vin_s3, /vout_s4, /vin_s4, /vout_s5, /vin_s5, /vout_s6, /vin_s6, /vout_s7, /vin_s7
Run mode: Single Run, Sweeps and Corners
Global variables:
  sigma = 3
Corners (all switched off):
  model folders: /cadstud/cds03/Cadence_Libraries/UMC_TECH/UMC_65/umc_65_ll_ver_B11PB/Models/Spectre, /cadstud/cds03/Cadence_Libraries/UMC_TECH/UMC_65/umc_65_ll_ver_B11PB/Models/Spectre/Monte_Carlo
  C0: temperature=-25 85; vdd=1.62 1.98; l65ll_v181.lib.scs[ss_ll_io25od33 ff_ll_io25od33 fnsp_ll_io25od33 snfp_ll_io25od33, ff_ll_res ss_ll_res], L65_MIMCAPS_20F_KF_V101_RF.lib.scs[ff ss]
  MC (off): vdd=1.8; l65ll_v181_mc.lib.scs[mc_ll_io25od33, mc_ll_res], L65_MIMCAPS_20F_KF_V101_RF_MC.lib.scs[mc]
  C0_0 (off): temperature=-25 85; vdd=1.62 1.98; l65ll_v181.lib.scs[ss_ll_io25od33 ff_ll_io25od33 fnsp_ll_io25od33 snfp_ll_io25od33, ff_ll_res ss_ll_res], L65_MIMCAPS_20F_KF_V101_RF.lib.scs[ff ss]
  MC_0 (off): vdd=1.8; l65ll_v181_mc.lib.scs[mc_ll_io25od33, mc_ll_res], L65_MIMCAPS_20F_KF_V101_RF_MC.lib.scs[mc]
Specs:
  aicd_lab_05_opamp_PGAandLPF_1 / DC Gain S0: range -1.5 to 1.5
  aicd_lab_05_opamp_PGAandLPF_1 / DC Gain S1: range 1.5 to 4.5
  aicd_lab_05_opamp_PGAandLPF_1 / DC Gain S2: range 4.5 to 7.5
  aicd_lab_05_opamp_PGAandLPF_1 / DC Gain S3: range 7.5 to 10.5
  aicd_lab_05_opamp_PGAandLPF_1 / DC Gain S4: range 10.5 to 13.5
  aicd_lab_05_opamp_PGAandLPF_1 / DC Gain S5: range 13.5 to 16.5
  aicd_lab_05_opamp_PGAandLPF_1 / DC Gain S6: range 16.5 to 19.5
  aicd_lab_05_opamp_PGAandLPF_1 / DC Gain S7: range 19.5 to 22.5
  aicd_lab_05_opamp_PGAandLPF_1 / DNL0: range -0.5 to 0.5
  aicd_lab_05_opamp_PGAandLPF_1 / DNL1: range -0.5 to 0.5
  aicd_lab_05_opamp_PGAandLPF_1 / DNL2: range -0.5 to 0.5
  aicd_lab_05_opamp_PGAandLPF_1 / DNL3: range -0.5 to 0.5
  aicd_lab_05_opamp_PGAandLPF_1 / DNL4: range -0.5 to 0.5
  aicd_lab_05_opamp_PGAandLPF_1 / DNL5: range -0.5 to 0.5
  aicd_lab_05_opamp_PGAandLPF_1 / DNL6: range -0.5 to 0.5
  aicd_lab_05_opamp_PGAandLPF_1 / DNL7: range -0.5 to 0.5
  aicd_lab_05_opamp_PGAandLPF_1 / INL: range -0.5 to 0.5
  aicd_lab_05_opamp_PGAandLPF_1 / FilterBW: range 50k to 150k
