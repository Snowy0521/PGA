ADE simulation setup
Run mode: Single Run, Sweeps and Corners
Tests:
  aicd_lab_05_opamp_PGAandLPF_1: aicd_lab_05_opamp/PGAandLPF_Testbench/config, simulator spectre
    Variables: v_offset = -1.888u; vb0_0 = 0; vb0_1 = 1.8; vb1_0 = 0; vb1_1 = 1.8; vb2_0 = 0; vb2_1 = 1.8; vcontrol = 1.8; vdd = 1.8; vcm = 0.9
    Outputs: cross(VS("/out_offset") 0.9 1 "rising" nil nil nil); input_offset; cross(dB20((VF("/out_s0") / VF("/in_filter"))) "-3" 1 "falling" nil nil nil); cross(dB20((VF("/vout_s0") / VF("/in_filter"))) "-3" 1 "falling" nil nil nil); FilterBW; BW Tolerance; Input Impedance; DC Gain S0; DC Gain S4; nil; DNL1; DNL2; DNL3; DNL4; DNL5; DNL6; DNL7; DNL; ((ymax(dB20((VF("/vout_s0") / VF("/vin_s0")))) - 0) / 3); (((ymax(dB20((VF("/vout_s0") / VF("/vin_s0")))) - 0) / 3) + ((ymax(dB20((VF("/vout_s1") / VF("/vin_s1")))) - 3) / 3)); INL
Global variables:
  sigma = 3
Corners (all switched off):
  model folders: /cadstud/cds03/Cadence_Libraries/UMC_TECH/UMC_65/umc_65_ll_ver_B11PB/Models/Spectre, /cadstud/cds03/Cadence_Libraries/UMC_TECH/UMC_65/umc_65_ll_ver_B11PB/Models/Spectre/Monte_Carlo
  C0: temperature=-25 85; vdd=1.62 1.98; l65ll_v181.lib.scs[ss_ll_io25od33 ff_ll_io25od33 fnsp_ll_io25od33 snfp_ll_io25od33, ff_ll_res ss_ll_res], L65_MIMCAPS_20F_KF_V101_RF.lib.scs[ff ss]
  MC (off): vdd=1.8; l65ll_v181_mc.lib.scs[mc_ll_io25od33, mc_ll_res], L65_MIMCAPS_20F_KF_V101_RF_MC.lib.scs[mc]
  C0_0 (off): temperature=-25 85; vdd=1.62 1.98; l65ll_v181.lib.scs[ss_ll_io25od33 ff_ll_io25od33 fnsp_ll_io25od33 snfp_ll_io25od33, ff_ll_res ss_ll_res], L65_MIMCAPS_20F_KF_V101_RF.lib.scs[ff ss]
  MC_0 (off): vdd=1.8; l65ll_v181_mc.lib.scs[mc_ll_io25od33, mc_ll_res], L65_MIMCAPS_20F_KF_V101_RF_MC.lib.scs[mc]
Specs:
  aicd_lab_05_opamp_PGAandLPF_1 / DC Gain S0: range -1.5 to 1.5
  aicd_lab_05_opamp_PGAandLPF_1 / DC Gain S1: range 1.5 to 4.5
  aicd_lab_05_opamp_PGAandLPF_1 / DC Gain S2: range 4.5 to 7.5
  aicd_lab_05_opamp_PGAandLPF_1 / DC Gain S3: range 7.5 to 10.5
  aicd_lab_05_opamp_PGAandLPF_1 / DC Gain S4: range 10.5 to 13.5
  aicd_lab_05_opamp_PGAandLPF_1 / DC Gain S5: range 13.5 to 16.5
  aicd_lab_05_opamp_PGAandLPF_1 / DC Gain S6: range 16.5 to 19.5
  aicd_lab_05_opamp_PGAandLPF_1 / DC Gain S7: range 19.5 to 22.5
  aicd_lab_05_opamp_PGAandLPF_1 / DNL0: range -0.5 to 0.5
  aicd_lab_05_opamp_PGAandLPF_1 / DNL1: range -0.5 to 0.5
  aicd_lab_05_opamp_PGAandLPF_1 / DNL2: range -0.5 to 0.5
  aicd_lab_05_opamp_PGAandLPF_1 / DNL3: range -0.5 to 0.5
  aicd_lab_05_opamp_PGAandLPF_1 / DNL4: range -0.5 to 0.5
  aicd_lab_05_opamp_PGAandLPF_1 / DNL5: range -0.5 to 0.5
  aicd_lab_05_opamp_PGAandLPF_1 / DNL6: range -0.5 to 0.5
  aicd_lab_05_opamp_PGAandLPF_1 / DNL7: range -0.5 to 0.5
  aicd_lab_05_opamp_PGAandLPF_1 / INL: range -0.5 to 0.5
  aicd_lab_05_opamp_PGAandLPF_1 / FilterBW: range 50k to 150k
